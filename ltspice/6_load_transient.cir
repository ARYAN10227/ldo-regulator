* LDO | Load step 1 mA -> 100 mA -> 1 mA with 1 us edges. Plot V(out).
* Open in LTspice (File > Open, file type *.cir) and Run. Keep ldo_core.inc in the same folder.
* After running: View > SPICE Error Log shows the .meas results.
.include ldo_core.inc
VIN vin 0 5
VINJ fbx ein 0
ILOAD out 0 PULSE(1m 100m 100u 1u 1u 400u 1m)
.tran 0 900u 0 20n
.meas TRAN vpre FIND V(out) AT=99u
.meas TRAN vmin MIN V(out) FROM=100u TO=200u
.meas TRAN undershoot PARAM vpre-vmin
.meas TRAN vmax MAX V(out) FROM=500u TO=600u
.end
