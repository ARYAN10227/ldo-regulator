* LDO | PSRR: 1 V AC on VIN. Plot  -20*log10(mag(V(out)))  or just V(out) in dB (PSRR = minus that).
* Open in LTspice (File > Open, file type *.cir) and Run. Keep ldo_core.inc in the same folder.
* After running: View > SPICE Error Log shows the .meas results.
.include ldo_core.inc
VIN vin 0 DC 5 AC 1
VINJ fbx ein 0
ILOAD out 0 100m
.ac dec 100 10 10Meg
.meas AC vout_1k FIND V(out) AT=1k
.meas AC vout_100k FIND V(out) AT=100k
.end
